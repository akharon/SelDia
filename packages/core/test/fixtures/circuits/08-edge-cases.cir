Edge-case netlist: continuation, comments, SI suffixes, mixed case
* full-line comment: ignored
* the source spec below is continued with a leading +
Vsrc in 0 PULSE(0 5 0 1n 1n 1u
+ 2u 4u)   ; inline comment after a continued element
Rin in mid 1MEG   ; 1 megohm, uppercase suffix
C1 mid 0 4.7U     ; uppercase micro suffix
R2 mid out 2.2k   ; lowercase kilo suffix
L1 out 0 100m     ; milli-henry
c2 out 0 100n     ; lowercase element letter, nano suffix
.op
.end
