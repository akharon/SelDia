RC low-pass filter
V1 in 0 AC 1
R1 in out 1k
C1 out 0 100n
.ac dec 10 1 100k
.print ac vdb(out)
.end
